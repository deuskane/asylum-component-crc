{
    name      : "CRC",
    width     : 8,
    desc      : "CSR for CRC"
    interface : "sbi"
    
    parameters : [
    ]

    registers : [
        {
            name         : "data0",
            address      : "x0",
            desc         : "Data byte 0 - a write of data0 processes data1:data0 (result readable one cycle later)",
            swaccess     : "rw",
            hwaccess     : "ro",
            fields: [
                {
                    name: "value",
                    bits: "7:0",
                    init: "d0",
                    desc: "Data Byte 0"
                },
            ]
        },
        {
            name       : "data1",
            address    : "x1",
            desc       : "Data byte 1 - bits 15:8 of the data word (write before data0, used when WIDTH_DATA > 8)",
            swaccess   : "rw",
            hwaccess   : "ro",
            fields: [
                {
                    name: "value",
                    bits: "7:0",
                    init: "d0",
                    desc: "Data Byte 1"
                },
            ]
        },
        {
            name       : "crc0",
            address    : "x2",
            desc       : "CRC byte 0 - write: raw CRC register bits 7:0 (seed), read: final CRC bits 7:0 (REFLECT_OUT then XOR_OUT applied)",
            swaccess   : "rw",
            hwaccess   : "rw",
            hwtype     : "ext",
            fields: [
                {
                    name: "value",
                    bits: "7:0",
                    init: "d0",
                    desc: "CRC Byte 0"
                },
            ]
        },
        {
            name       : "crc1",
            address    : "x3",
            desc       : "CRC byte 1 - write: raw CRC register bits 15:8 (seed), read: final CRC bits 15:8 (REFLECT_OUT then XOR_OUT applied)",
            swaccess   : "rw",
            hwaccess   : "rw",
            hwtype     : "ext",
            fields: [
                {
                    name: "value",
                    bits: "7:0",
                    init: "d0",
                    desc: "CRC Byte 1"
                },
            ]
        },
    ]
}
